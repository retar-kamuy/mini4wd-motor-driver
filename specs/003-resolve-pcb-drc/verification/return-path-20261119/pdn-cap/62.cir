Passive PDN sensitivity with selected22uF local candidate; not TPS61023 loop
Vsrc src 0 4.903554936103582
Vctl ctl 0 PWL(0 1 15u 1 15.001u 0 4e-05 0 4.0001000000000005e-05 1)
Ssrc src bulk ctl 0 CUT
.model CUT SW(Ron=.001 Roff=1e12 Vt=.5 Vh=.05)
Rbulk bulk cb .01
Cbulk cb 0 1e-05
Rtrace bulk li 0.25
Ltrace li pin 1e-08
Rlocal pin cl .02
Llocal cl cc 1n
Clocal cc 0 1e-06
Rfast pin cf .02
Lfast cf cff 1n
Cfast cff 0 60n
Idc pin 0 0.05
Igate pin 0 PWL(0 0 20u 0 20.3u 1 20.6u 0 29.314u 0 30.514u .25 31.714u 0)
.options method=gear reltol=.0005
.tran 2n 45u
.meas tran vmin MIN v(pin) FROM=15u TO=45u
.meas tran vmax MAX v(pin) FROM=15u TO=45u
.end
