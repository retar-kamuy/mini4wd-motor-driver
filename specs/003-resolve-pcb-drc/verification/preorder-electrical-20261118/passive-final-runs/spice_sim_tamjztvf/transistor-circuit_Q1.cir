* Auto-generated testbench for N-channel MOSFET: Q1 (SiSS64DN-T1-GE3)
* Load type: motor
* Flyback diode: D1
* Model: generic NMOS (Vth=1.5V) — real threshold depends on part

* Generic semiconductor models for Phase 1 simulation
.model D_GENERIC D(IS=1e-14 N=1.05 BV=100 IBV=1e-10)
.model D_SCHOTTKY D(IS=1e-6 N=1.05 BV=40 IBV=1e-8 RS=0.5)
.model D_ZENER3V3 D(IS=1e-14 N=1.05 BV=3.3 IBV=5e-3)
.model D_ZENER5V1 D(IS=1e-14 N=1.05 BV=5.1 IBV=5e-3)
.model NPN_GENERIC NPN(IS=1e-14 BF=200 VAF=100 CJC=5p CJE=10p TF=0.3n)
.model PNP_GENERIC PNP(IS=1e-14 BF=200 VAF=100 CJC=5p CJE=10p TF=0.6n)
.model NMOS_GENERIC NMOS(VTO=1.5 KP=1e-2 LAMBDA=0.01)
.model PMOS_GENERIC PMOS(VTO=-1.5 KP=5e-3 LAMBDA=0.01)

VDD vdd 0 DC 3.3

* N-channel MOSFET: drain to load, source to GND
RLOAD vdd MOTOR_MINUS 1k
MQ1 MOTOR_MINUS Q1_GATE 0 0 NMOS_GENERIC L=1u W=100u

* Gate drive: sweep from 0V (off) to VDD (on)
Vgate Q1_GATE 0 DC 0

.control
dc Vgate 0 3.3 0.033
let id = abs(i(VDD))
meas dc vth when id=1m
let i_on = vecmax(id)
echo "vth=$&vth i_on=$&i_on vdd=3.3" > transistor-circuit_Q1.out
quit
.endc

.end
