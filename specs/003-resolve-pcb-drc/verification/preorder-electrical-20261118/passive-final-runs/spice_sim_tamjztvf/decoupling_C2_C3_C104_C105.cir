* Auto-generated testbench for decoupling analysis: BOOST_5V rail
* 4 capacitor(s) in parallel, series R-L-C model
* Model: ESR/ESL from pdn_impedance (package-based)

R_esr_C2 rail n_esr_0 21.3m
L_par_C2 n_esr_0 n_lpar_0 700p
C2 n_lpar_0 0 22u
R_esr_C3 rail n_esr_1 21.3m
L_par_C3 n_esr_1 n_lpar_1 700p
C3 n_lpar_1 0 22u
R_esr_C104 rail n_esr_2 948.7m
L_par_C104 n_esr_2 n_lpar_2 500p
C104 n_lpar_2 0 100n
R_esr_C105 rail n_esr_3 67.4m
L_par_C105 n_esr_3 n_lpar_3 700p
C105 n_lpar_3 0 2.2u

* 1A AC current source into the rail node — V(rail) = Z(f)
IAC 0 rail DC 0 AC 1

.control
ac dec 200 100 100Meg
let z_mag = vm(rail)
meas ac z_min min z_mag
meas ac f_at_zmin when z_mag=z_min
meas ac z_at_1M find vm(rail) at=1Meg
meas ac z_at_100k find vm(rail) at=100k
echo "z_min=$&z_min f_at_zmin=$&f_at_zmin z_at_1M=$&z_at_1M z_at_100k=$&z_at_100k n_caps=4" > decoupling_C2_C3_C104_C105.out
quit
.endc

.end
