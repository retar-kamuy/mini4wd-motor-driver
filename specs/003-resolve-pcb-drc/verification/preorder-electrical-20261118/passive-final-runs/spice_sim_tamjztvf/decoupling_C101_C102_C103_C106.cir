* Auto-generated testbench for decoupling analysis: MCU_3V3 rail
* 4 capacitor(s) in parallel, series R-L-C model
* Model: ESR/ESL from pdn_impedance (package-based)

R_esr_C101 rail n_esr_0 948.7m
L_par_C101 n_esr_0 n_lpar_0 500p
C101 n_lpar_0 0 100n
R_esr_C102 rail n_esr_1 948.7m
L_par_C102 n_esr_1 n_lpar_1 500p
C102 n_lpar_1 0 100n
R_esr_C103 rail n_esr_2 948.7m
L_par_C103 n_esr_2 n_lpar_2 500p
C103 n_lpar_2 0 100n
R_esr_C106 rail n_esr_3 948.7m
L_par_C106 n_esr_3 n_lpar_3 500p
C106 n_lpar_3 0 100n

* 1A AC current source into the rail node — V(rail) = Z(f)
IAC 0 rail DC 0 AC 1

.control
ac dec 200 100 100Meg
let z_mag = vm(rail)
meas ac z_min min z_mag
meas ac f_at_zmin when z_mag=z_min
meas ac z_at_1M find vm(rail) at=1Meg
meas ac z_at_100k find vm(rail) at=100k
echo "z_min=$&z_min f_at_zmin=$&f_at_zmin z_at_1M=$&z_at_1M z_at_100k=$&z_at_100k n_caps=4" > decoupling_C101_C102_C103_C106.out
quit
.endc

.end
